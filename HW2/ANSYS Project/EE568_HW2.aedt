# Ansys Electronics Desktop project, version 2025.2
materials:
  vacuum: permittivity=1
  M19_24G: permeability{HUnit=A_per_meter BUnit=tesla curve (0, 0) (22.28, 0.05) (31.83, 0.2) (47.74, 0.4) (63.66, 0.55) (79.58, 0.65) (95.49, 0.75) (111.41, 0.83) (175.07, 1) (397.85, 1.3) (875.27, 1.5) (1591.5, 1.61) (3183, 1.72) (6366, 1.85) (15915, 1.95) (31831, 2.05)} conductivity=2080000 stacking_type=Lamination stacking_factor=0.95 stacking_direction=V(3)
  NdFe30: permittivity=1 permeability=1.044573 conductivity=625000 magnetic_coercivity{Magnitude=-838000A_per_meter DirComp1=1 DirComp2=0 DirComp3=0} lande_g_factor=2
  NdFeB_Br1p3: permeability=1.05 magnetic_coercivity{Magnitude=-985000A_per_meter DirComp1=1 DirComp2=0 DirComp3=0}

design Maxwell2DDesign1 (Maxwell 2D, Magnetostatic, XY geometry, model units mm)
options: ModelDepth=0.102meter
variables:
  stator_angle = 0deg
  rotor_angle = 0deg
geometry:
  coordinate_system stator_cs = origin=(0mm, 0mm, 0mm) Euler Angle ZYZ phi=stator_angle theta=0deg psi=0deg
  stator_outer [M19_24G, oriented by stator_cs] = imported_body()
  rotor_iron [M19_24G] = circle(normal=Z, centre=(0mm, 0mm, 0mm), radius=26mm)
  coordinate_system rotor_cs = origin=(0mm, 0mm, 0mm) Euler Angle ZYZ phi=rotor_angle theta=0deg psi=0deg
  coordinate_system pm0_cs = origin=(0mm, 0mm, 0mm) x=(10.516712mm, 25.389589mm, 0mm) y=(-25.389589mm, 10.516712mm, 0mm) in rotor_cs
  pm_0 [NdFeB_Br1p3, oriented by pm0_cs] = circle(normal=Z, centre=(0mm, 0mm, 0mm), radius=30mm)
  Rectangle3 = rectangle(corner=(0mm, 0mm, 0mm), x_size=-30mm, y_size=45mm)
  Rectangle4 = rectangle(corner=(0mm, 0mm, 0mm), x_size=-25mm, y_size=40mm)
  Rectangle4.rotate(axis=Z, angle=-40deg)
  Rectangle4.move(19.151111mm, -16.06969mm, 0mm)
  Rectangle5 = rectangle(corner=(50mm, -35mm, 0mm), x_size=-100mm, y_size=40mm)
  [Rectangle3, Rectangle4].rotate(axis=Z, angle=-2.5deg)
  pm_0.subtract(Rectangle3, Rectangle4, Rectangle5)
  rotor_iron_1 = rotor_iron.copy()
  pm_0.subtract(rotor_iron_1)
  pm_1 [NdFeB_Br1p3, oriented by pm1_cs], pm_2 [NdFeB_Br1p3, oriented by pm2_cs], pm_3 [NdFeB_Br1p3, oriented by pm3_cs], pm_4 [NdFeB_Br1p3, oriented by pm4_cs], pm_5 [NdFeB_Br1p3, oriented by pm5_cs], pm_6 [NdFeB_Br1p3, oriented by pm6_cs], pm_7 [NdFeB_Br1p3, oriented by pm7_cs] = pm_0.duplicate_around_axis(axis=Z, angle=-45deg, total=8)
  coordinate_system pm1_cs = origin=(0mm, 0mm, 0mm) x=(-25.389589mm, -10.516712mm, 0mm) y=(10.516712mm, -25.389589mm, 0mm) in rotor_cs
  coordinate_system pm2_cs = origin=(0mm, 0mm, 0mm) x=(25.389589mm, -10.516712mm, 0mm) y=(10.516712mm, 25.389589mm, 0mm) in rotor_cs
  coordinate_system pm3_cs = origin=(0mm, 0mm, 0mm) x=(-10.516712mm, 25.389589mm, 0mm) y=(-25.389589mm, -10.516712mm, 0mm) in rotor_cs
  coordinate_system pm4_cs = origin=(0mm, 0mm, 0mm) x=(-10.516712mm, -25.389589mm, 0mm) y=(25.389589mm, -10.516712mm, 0mm) in rotor_cs
  coordinate_system pm5_cs = origin=(0mm, 0mm, 0mm) x=(25.389589mm, 10.516712mm, 0mm) y=(-10.516712mm, 25.389589mm, 0mm) in rotor_cs
  coordinate_system pm6_cs = origin=(0mm, 0mm, 0mm) x=(-25.389589mm, 10.516712mm, 0mm) y=(-10.516712mm, -25.389589mm, 0mm) in rotor_cs
  coordinate_system pm7_cs = origin=(0mm, 0mm, 0mm) x=(10.516712mm, -25.389589mm, 0mm) y=(25.389589mm, 10.516712mm, 0mm) in rotor_cs
  slot_L_15 [vacuum, oriented by stator_cs] = rectangle(corner=(0mm, 31mm, 0mm), x_size=-2.245mm, y_size=11.36mm)
  slot_R_15 [vacuum, oriented by stator_cs] = rectangle(corner=(0mm, 31mm, 0mm), x_size=2.245mm, y_size=11.36mm)
  [slot_L_15, slot_R_15].rotate(axis=Z, angle=24deg)
  slot_R_1..slot_R_14 [vacuum, oriented by stator_cs] = slot_R_15.duplicate_around_axis(axis=Z, angle=-24deg, total=15)
  slot_L_1..slot_L_14 [vacuum, oriented by stator_cs] = slot_L_15.duplicate_around_axis(axis=Z, angle=-24deg, total=15)
  inner_air, outer [vacuum] = imported_body()
  Circle1 [vacuum, oriented by stator_cs] = imported_body()
  point Point1 = (-27.6mm, 13.2mm, 0mm) in stator_cs
  [pm_1, pm_0, pm_7, pm_6, pm_5, pm_4, pm_3, pm_2, rotor_iron, inner_air].rotate(axis=Z, angle=rotor_angle) in pm7_cs
boundaries and excitations:
  OuterFluxTangential: Vector Potential Edges=outer.edge(at (-75, 0, 0)) Value=0
  slot_R_1: Coil Objects=slot_R_1 Conductor_number=4 Winding=Phase_A PolarityType=Positive
  slot_L_1: Coil Objects=slot_L_1 Conductor_number=4 Winding=Phase_C PolarityType=Negative
  slot_R_2: Coil Objects=slot_R_2 Conductor_number=4 Winding=Phase_C PolarityType=Negative
  slot_L_2: Coil Objects=slot_L_2 Conductor_number=4 Winding=Phase_A PolarityType=Negative
  slot_R_3: Coil Objects=slot_R_3 Conductor_number=4 Winding=Phase_A PolarityType=Negative
  slot_L_3: Coil Objects=slot_L_3 Conductor_number=4 Winding=Phase_C PolarityType=Positive
  slot_R_4: Coil Objects=slot_R_4 Conductor_number=4 Winding=Phase_C PolarityType=Positive
  slot_L_4: Coil Objects=slot_L_4 Conductor_number=4 Winding=Phase_A PolarityType=Positive
  slot_R_5: Coil Objects=slot_R_5 Conductor_number=4 Winding=Phase_A PolarityType=Positive
  slot_L_5: Coil Objects=slot_L_5 Conductor_number=4 Winding=Phase_C PolarityType=Negative
  slot_R_6: Coil Objects=slot_R_6 Conductor_number=4 Winding=Phase_B PolarityType=Positive
  slot_L_6: Coil Objects=slot_L_6 Conductor_number=4 Winding=Phase_A PolarityType=Negative
  slot_R_7: Coil Objects=slot_R_7 Conductor_number=4 Winding=Phase_A PolarityType=Negative
  slot_L_7: Coil Objects=slot_L_7 Conductor_number=4 Winding=Phase_B PolarityType=Negative
  slot_R_8: Coil Objects=slot_R_8 Conductor_number=4 Winding=Phase_B PolarityType=Negative
  slot_L_8: Coil Objects=slot_L_8 Conductor_number=4 Winding=Phase_A PolarityType=Positive
  slot_R_9: Coil Objects=slot_R_9 Conductor_number=4 Winding=Phase_A PolarityType=Positive
  slot_L_9: Coil Objects=slot_L_9 Conductor_number=4 Winding=Phase_B PolarityType=Positive
  slot_R_10: Coil Objects=slot_R_10 Conductor_number=4 Winding=Phase_B PolarityType=Positive
  slot_L_10: Coil Objects=slot_L_10 Conductor_number=4 Winding=Phase_A PolarityType=Negative
  slot_R_11: Coil Objects=slot_R_11 Conductor_number=4 Winding=Phase_C PolarityType=Positive
  slot_L_11: Coil Objects=slot_L_11 Conductor_number=4 Winding=Phase_B PolarityType=Negative
  slot_R_12: Coil Objects=slot_R_12 Conductor_number=4 Winding=Phase_B PolarityType=Negative
  slot_L_12: Coil Objects=slot_L_12 Conductor_number=4 Winding=Phase_C PolarityType=Negative
  slot_R_13: Coil Objects=slot_R_13 Conductor_number=4 Winding=Phase_C PolarityType=Negative
  slot_L_13: Coil Objects=slot_L_13 Conductor_number=4 Winding=Phase_B PolarityType=Positive
  slot_R_14: Coil Objects=slot_R_14 Conductor_number=4 Winding=Phase_B PolarityType=Positive
  slot_L_14: Coil Objects=slot_L_14 Conductor_number=4 Winding=Phase_C PolarityType=Positive
  slot_R_15: Coil Objects=slot_R_15 Conductor_number=4 Winding=Phase_C PolarityType=Positive
  slot_L_15: Coil Objects=slot_L_15 Conductor_number=4 Winding=Phase_B PolarityType=Negative
  Phase_A: Winding Group Type=Current IsSolid=false Current=27A ParallelBranchesNum=1
  Phase_B: Winding Group Type=Current IsSolid=false Current=27A ParallelBranchesNum=1
  Phase_C: Winding Group Type=Current IsSolid=false Current=27A ParallelBranchesNum=1
parameters:
  rotor_torque: Torque Coordinate_System=Global Is_Positive=true Objects=[rotor_iron, pm_6, pm_7, pm_0..pm_5, inner_air]
mesh:
  air_gap_mesh: LengthBased Objects=[Circle1, inner_air] MaxLength=0.25mm
  edge_mesh: LengthBased Edges=pm_5.edge(at (-27.7164, -11.4805, 0)) inner_air.edge(at (-20.6438, -18.9165, 0), at (-18.9165, -20.6438, 0), at (-11.4805, -27.7164, 0), at (-1.22134, -27.9734, 0), at (1.22134, -27.9734, 0), at (11.4805, -27.7164, 0), at (18.9165, -20.6438, 0), at (20.6438, -18.9165, 0), at (27.7164, -11.4805, 0), at (27.9734, -1.22134, 0), at (27.9734, 1.22134, 0), at (27.7164, 11.4805, 0)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) rotor_iron.edge(at (-26, 0, 0)) pm_3.edge(at (18.9165, -20.6438, 0)) pm_7.edge(at (-11.4805, 27.7164, 0)) pm_6.edge(at (-27.7164, 11.4805, 0)) Circle1.edge(at (-30.8302, -3.24038, 0), at (-29.4828, 9.57953, 0), at (-23.0375, 20.743, 0), at (-12.6088, 28.3199, 0), at (0, 31, 0), at (12.6088, 28.3199, 0), at (23.0375, 20.743, 0), at (29.4828, 9.57953, 0), at (30.8302, -3.24038, 0), at (26.8468, -15.5, 0), at (18.2213, -25.0795, 0), at (6.44526, -30.3226, 0)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) slot_L_12.edge(at (-36.4791, -3.8341, 0), at (-42.0106, -5.54418, 0), at (-36.2444, -6.06681, 0)) slot_R_12.edge(at (-42.2453, -3.31147, 0), at (-36.7137, -1.6014, 0)) slot_R_13.edge(at (-34.191, 13.4699, 0), at (-39.9399, 14.1575, 0)) slot_L_13.edge(at (-34.8848, 11.3347, 0), at (-35.5785, 9.19962, 0), at (-40.6336, 12.0224, 0)) slot_L_14.edge(at (-28.7608, 22.8754, 0), at (-27.2586, 24.5437, 0), at (-32.2307, 27.5102, 0)) stator_outer.edge(at (-25.7261, 26.1848, 0), at (6.44526, 30.3226, 0), at (18.2213, 25.0795, 0), at (26.8468, 15.5, 0), at (30.8302, 3.24038, 0), at (29.4828, -9.57953, 0), at (23.0375, -20.743, 0), at (12.6088, -28.3199, 0)) slot_R_14.edge(at (-30.7285, 29.1786, 0)) slot_R_15.edge(at (-12.8682, 34.422, 0), at (-14.9191, 33.5088, 0), at (-16.2039, 39.1543, 0)) slot_L_15.edge(at (-16.97, 32.5957, 0), at (-18.2548, 38.2412, 0)) slot_R_1.edge(at (2.245, 36.68, 0), at (1.1225, 42.36, 0)) slot_L_1.edge(at (0, 36.68, 0), at (-2.245, 36.68, 0), at (-1.1225, 42.36, 0)) slot_R_2.edge(at (16.97, 32.5957, 0), at (18.2548, 38.2412, 0)) slot_L_2.edge(at (14.9191, 33.5088, 0), at (12.8682, 34.422, 0), at (16.2039, 39.1543, 0)) slot_R_3.edge(at (28.7608, 22.8754, 0), at (32.2307, 27.5102, 0)) slot_L_3.edge(at (27.2586, 24.5437, 0), at (25.7564, 26.2121, 0), at (30.7285, 29.1786, 0)) slot_R_4.edge(at (40.6336, 12.0224, 0), at (35.5785, 9.19962, 0), at (29.8296, 8.51197, 0)) slot_L_4.edge(at (39.9399, 14.1575, 0), at (34.8848, 11.3347, 0), at (34.191, 13.4699, 0)) slot_L_5.edge(all 4) slot_R_5.edge(at (36.2444, -6.06681, 0), at (42.0106, -5.54418, 0)) slot_L_6.edge(at (32.8883, -16.3958, 0), at (31.7658, -18.34, 0), at (37.2461, -20.2079, 0)) slot_R_6.edge(at (30.6433, -20.2842, 0), at (36.1236, -22.1521, 0)) slot_L_10.edge(at (-19.7437, -30.9943, 0), at (-21.56, -29.6747, 0), at (-23.9905, -34.9297, 0)) slot_R_10.edge(at (-23.3762, -28.3552, 0), at (-25.8067, -33.6102, 0)) slot_L_11.edge(at (-36.1236, -22.1521, 0), at (-31.7658, -18.34, 0), at (-30.6433, -20.2842, 0)) slot_R_11.edge(at (-37.2461, -20.2079, 0), at (-32.8883, -16.3958, 0)) slot_R_9.edge(at (-9.90511, -41.201, 0), at (-9.82214, -35.4117, 0)) slot_L_9.edge(at (-7.70917, -41.6677, 0), at (-7.6262, -35.8785, 0), at (-5.43026, -36.3452, 0)) slot_R_8.edge(at (7.70917, -41.6677, 0), at (5.43026, -36.3452, 0)) slot_L_8.edge(at (9.90511, -41.201, 0), at (7.6262, -35.8785, 0), at (9.82214, -35.4117, 0)) slot_R_7.edge(at (19.7437, -30.9943, 0), at (23.9905, -34.9297, 0)) slot_L_7.edge(at (21.56, -29.6747, 0), at (25.8067, -33.6102, 0), at (23.3762, -28.3552, 0)) MaxLength=0.3mm
  Length1: LengthBased RefineInside Objects=[stator_outer, rotor_iron] MaxLength=5mm
  initial mesh: GlobalSurfApproximation{CurvedSurfaceApproxChoice=UseSlider SliderMeshSettings=9} GlobalModelRes{DefeatureLength=0.0005mm}
setups:
  Setup1: Magnetostatic MaximumPasses=10 MinimumPasses=2 MinimumConvergedPasses=1 PercentRefinement=30 PercentError=1 NonLinearResidual=0.0001
optimetrics:
  ParametricSetup1: Parametric Sim._Setups=[Setup1]
    sweep rotor_angle: LIN 0deg 90deg 1deg
    calculate rotor_torque.Torque on Setup1 : LastAdaptive
    calculate FluxLinkage(Phase_A) on Setup1 : LastAdaptive
    calculate FluxLinkage(Phase_B) on Setup1 : LastAdaptive
    calculate FluxLinkage(Phase_C) on Setup1 : LastAdaptive
field calculator expressions:
  Bx_probe = Fundamental_Quantity(22) | ScalarX
  By_probe = Fundamental_Quantity(22) | ScalarY
field plots:
  B_Vector1: B over stator_outer, rotor_iron, pm_0..pm_7, inner_air, slot_L_15, slot_R_15, slot_R_1..slot_R_14, slot_L_1..slot_L_14, Circle1 on Setup1 : LastAdaptive
  Mesh1: MeshPlots over stator_outer, rotor_iron, pm_0..pm_7, inner_air, outer, slot_L_15, slot_R_15, slot_R_1..slot_R_14, slot_L_1..slot_L_14, Circle1 on Setup1 : LastAdaptive
reports:
  Calculator Expressions Plot1: Bx_probe, By_probe vs stator_angle on Setup1 : LastAdaptive [rotor_angle=all]
